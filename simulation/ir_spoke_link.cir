* IR Spoke Sensor - component-valued custom receiver and remote LED board
* Values and electrical topology are generated from their canonical sources.
.include generated_params.inc
.include generated_connectivity.inc
.include models/TLV9062_typ_ngspice.lib

.param SPOKE_PERIOD=4.135121m
.param SPOKE_BLOCK=168.48u
.param TRAN_STOP=16m

* Wheel mask: a periodic low pulse with one blockage centred in every transient.
VSPOKE SPOKE GND PULSE(1 0.05 {TRAN_STOP/2-SPOKE_BLOCK/2} 1u 1u {SPOKE_BLOCK} {SPOKE_PERIOD})
* The LED forward voltage remains near Vf even at leakage current. Derive the
* optical carrier from >1 mA through the real 39-ohm series resistor instead.
BCARRIER CARRIER GND V=ternary_fcn(V(+3V3_LED,LED_A)>0.039,1,0)

.model S8050 NPN(BF=180 VAF=80 IS=1e-13 CJE=20p CJC=8p TF=20n)
.model IRLED D(IS=1e-20 N=1.8 RS=2 CJO=20p TT=10n BV=5 IBV=10u)

.tran 0.1u {TRAN_STOP}
.control
run
set wr_singlescale
set wr_vecnames
let SUPPLY_CURRENT=-i(V3V3)
wrdata ../build/simulation/spice_waveforms.csv v(TX_CARRIER_GPIO1) v(SPOKE) v(TIA_OUT) v(BANDPASS) v(COMP_OUT) v(RX_RMT_GPIO2) SUPPLY_CURRENT
meas tran TIA_MIN min v(TIA_OUT) from=2m to=16m
meas tran TIA_MAX max v(TIA_OUT) from=2m to=16m
meas tran BP_PP pp v(BANDPASS) from=2m to=16m
meas tran SUPPLY_I_AVG avg SUPPLY_CURRENT from=2m to=16m
meas tran SUPPLY_I_MAX max SUPPLY_CURRENT from=2m to=16m
quit
.endc
.end
